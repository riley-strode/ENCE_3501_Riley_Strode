* Output Register testbench (muddLib07 flopr_c_1x x4)
* Self-contained: no .include files needed. Open in LTspice and Run.

* ===== CMOSedu long-channel models (from cmosedu_models.txt) =====
*

* Long channel models from CMOS Circuit Design, Layout, and Simulation,

* Level=3 models VDD=5V, see CMOSedu.com

*

.MODEL N_1u NMOS LEVEL  = 3

+ TOX    = 200E-10         NSUB   = 1E17            GAMMA  = 0.5

+ PHI    = 0.7             VTO    = 0.8             DELTA  = 3.0

+ UO     = 650             ETA    = 3.0E-6          THETA  = 0.1

+ KP     = 120E-6          VMAX   = 1E5             KAPPA  = 0.3

+ RSH    = 0               NFS    = 1E12            TPG    = 1

+ XJ     = 500E-9          LD     = 100E-9

+ CGDO   = 200E-12         CGSO   = 200E-12         CGBO   = 1E-10

+ CJ     = 400E-6          PB     = 1               MJ     = 0.5

+ CJSW   = 300E-12         MJSW   = 0.5

*

.MODEL P_1u PMOS LEVEL  = 3

+ TOX    = 200E-10         NSUB   = 1E17            GAMMA  = 0.6

+ PHI    = 0.7             VTO    = -0.9            DELTA  = 0.1

+ UO     = 250             ETA    = 0               THETA  = 0.1

+ KP     = 40E-6           VMAX   = 5E4             KAPPA  = 1

+ RSH    = 0               NFS    = 1E12            TPG    = -1

+ XJ     = 500E-9          LD     = 100E-9

+ CGDO   = 200E-12         CGSO   = 200E-12         CGBO   = 1E-10

+ CJ     = 400E-6          PB     = 1               MJ     = 0.5

+ CJSW   = 300E-12         MJSW   = 0.5

*

*

* ===== muddLib07 cells + register subcircuits =====
* muddLib07 cells (lambda = 0.3um) extracted from the schematic views.
* Model names N_1u / P_1u = CMOSedu long-channel Level-3 models (5 V).
* extracted from muddLib07 inv_1x{sch}: 2 FETs
.subckt inv_1x a y vdd gnd
Mnmos_0 y a gnd gnd N_1u W=2.10u L=0.60u
Mpmos_0 vdd a y vdd P_1u W=3.00u L=0.60u
.ends inv_1x

* extracted from muddLib07 nand2_1x{sch}: 4 FETs
.subckt nand2_1x a b y vdd gnd
Mnmos_0 y b n1 gnd N_1u W=3.60u L=0.60u
Mnmos_1 n1 a gnd gnd N_1u W=3.60u L=0.60u
Mpmos_0 vdd b y vdd P_1u W=3.60u L=0.60u
Mpmos_1 vdd a y vdd P_1u W=3.60u L=0.60u
.ends nand2_1x

* extracted from muddLib07 buftri_c_1x{sch}: 8 FETs
.subckt buftri_c_1x d en y vdd gnd
Mnmos_0 n1 n2 gnd gnd N_1u W=4.20u L=0.60u
Mnmos_1 y en n1 gnd N_1u W=4.20u L=0.60u
Mnmos_2 n3 en gnd gnd N_1u W=1.80u L=0.60u
Mnmos_3 n2 d gnd gnd N_1u W=1.80u L=0.60u
Mpmos_0 n4 n3 y vdd P_1u W=6.00u L=0.60u
Mpmos_1 vdd n2 n4 vdd P_1u W=6.00u L=0.60u
Mpmos_2 vdd en n3 vdd P_1u W=2.70u L=0.60u
Mpmos_3 vdd d n2 vdd P_1u W=2.70u L=0.60u
.ends buftri_c_1x

* extracted from muddLib07 flopr_c_1x{sch}: 30 FETs
.subckt flopr_c_1x d ph1 ph2 q resetb vdd gnd
Mnmos_2 masterb ph2buf masterinb gnd N_1u W=1.80u L=0.60u
Mnmos_3 master masterb gnd gnd N_1u W=1.80u L=0.60u
Mnmos_4 slave ph1buf master gnd N_1u W=1.80u L=0.60u ; weak
Mnmos_5 masterb ph2b n6 gnd N_1u W=1.20u L=0.60u
Mnmos_6 n6 master gnd gnd N_1u W=1.20u L=0.60u
Mnmos_7 n8 slaveb gnd gnd N_1u W=1.20u L=0.60u
Mnmos_8 slaveb slave gnd gnd N_1u W=1.80u L=0.60u
Mnmos_10 slave ph1b n8 gnd N_1u W=1.20u L=0.60u
Mnmos_11 q slaveb gnd gnd N_1u W=2.10u L=0.60u
Mnmos_17 n1 resetb gnd gnd N_1u W=7.20u L=0.60u
Mnmos_19 masterinb d n1 gnd N_1u W=1.80u L=0.60u
Mnmos_22 ph2b ph2 gnd gnd N_1u W=1.80u L=0.60u
Mnmos_25 ph2buf ph2b gnd gnd N_1u W=1.80u L=0.60u
Mnmos_26 ph1buf ph1b gnd gnd N_1u W=1.80u L=0.60u
Mnmos_27 ph1b ph1 gnd gnd N_1u W=1.80u L=0.60u
Mpmos_2 masterinb ph2b masterb vdd P_1u W=1.80u L=0.60u
Mpmos_3 vdd masterb master vdd P_1u W=2.70u L=0.60u
Mpmos_4 master ph1b slave vdd P_1u W=1.80u L=0.60u ; weak
Mpmos_5 n7 ph2buf masterb vdd P_1u W=1.20u L=0.60u
Mpmos_6 vdd master n7 vdd P_1u W=1.20u L=0.60u
Mpmos_7 vdd slaveb n9 vdd P_1u W=1.20u L=0.60u
Mpmos_8 vdd slave slaveb vdd P_1u W=2.70u L=0.60u
Mpmos_10 n9 ph1buf slave vdd P_1u W=1.20u L=0.60u
Mpmos_11 vdd slaveb q vdd P_1u W=3.00u L=0.60u
Mpmos_16 vdd d masterinb vdd P_1u W=3.60u L=0.60u
Mpmos_18 vdd resetb masterinb vdd P_1u W=1.80u L=0.60u
Mpmos_21 vdd ph1 ph1b vdd P_1u W=2.70u L=0.60u
Mpmos_22 vdd ph2 ph2b vdd P_1u W=2.70u L=0.60u
Mpmos_24 vdd ph1b ph1buf vdd P_1u W=2.70u L=0.60u
Mpmos_25 vdd ph2b ph2buf vdd P_1u W=2.70u L=0.60u
.ends flopr_c_1x

* ================================================================
* INPUT REGISTER  (Logisim: 4 controlled buffers, shared EnableIn)
*   B[i] = DataIn[i] when EnableIn=1, else Hi-Z
* ================================================================
.subckt InputRegister EnableIn DataIn0 DataIn1 DataIn2 DataIn3 B0 B1 B2 B3 vdd gnd
Xb0 DataIn0 EnableIn B0 vdd gnd buftri_c_1x
Xb1 DataIn1 EnableIn B1 vdd gnd buftri_c_1x
Xb2 DataIn2 EnableIn B2 vdd gnd buftri_c_1x
Xb3 DataIn3 EnableIn B3 vdd gnd buftri_c_1x
.ends InputRegister

* ================================================================
* OUTPUT REGISTER (Logisim: 4 DFFs, clk = NAND(EnableOut,MainClock),
*                  R = NOT MainReset)
*   ph1 = NAND(EnableOut,MainClock)   (Logisim clock net)
*   ph2 = NOT ph1                     (master-latch phase)
*   resetb = MainReset                (flopr resetb is active-low, so
*                                      Logisim's inverter is absorbed)
* Loads on the FALLING edge of MainClock while EnableOut = 1.
* NOTE: flopr_c_1x reset is synchronous (needs a clock edge).
* ================================================================
.subckt OutputRegister MainReset MainClock EnableOut IB0 IB1 IB2 IB3 rOut0 rOut1 rOut2 rOut3 vdd gnd
Xck EnableOut MainClock ph1 vdd gnd nand2_1x
Xph ph1 ph2 vdd gnd inv_1x
Xf0 IB0 ph1 ph2 rOut0 MainReset vdd gnd flopr_c_1x
Xf1 IB1 ph1 ph2 rOut1 MainReset vdd gnd flopr_c_1x
Xf2 IB2 ph1 ph2 rOut2 MainReset vdd gnd flopr_c_1x
Xf3 IB3 ph1 ph2 rOut3 MainReset vdd gnd flopr_c_1x
.ends OutputRegister

* ===== Testbench =====
VDD vdd 0 DC 5

VCLK MainClock 0 PULSE(0 5 10n 0.2n 0.2n 19.8n 40n)
VENO EnableOut 0 PWL(0n 0 5n 0 5.2n 5 195n 5 195.2n 0 275n 0 275.2n 5)
VRST MainReset 0 PWL(0n 0 85n 0 85.2n 5 355n 5 355.2n 0 395n 0 395.2n 5)
VIB0 IB0 0 PWL(0n 0 55n 0 55.2n 5 95n 5 95.2n 0 135n 0 135.2n 5 255n 5 255.2n 0 335n 0 335.2n 5 375n 5 375.2n 0 415n 0 415.2n 5)
VIB1 IB1 0 PWL(0n 0 15n 0 15.2n 5 55n 5 55.2n 0 135n 0 135.2n 5 215n 5 215.2n 0 255n 0 255.2n 5 295n 5 295.2n 0 335n 0 335.2n 5)
VIB2 IB2 0 PWL(0n 0 55n 0 55.2n 5 135n 5 135.2n 0 175n 0 175.2n 5 215n 5 215.2n 0 255n 0 255.2n 5 295n 5 295.2n 0 335n 0 335.2n 5 415n 5 415.2n 0)
VIB3 IB3 0 PWL(0n 0 15n 0 15.2n 5 55n 5 55.2n 0 95n 0 95.2n 5 135n 5 135.2n 0 175n 0 175.2n 5 255n 5 255.2n 0 295n 0 295.2n 5 335n 5 335.2n 0 375n 0 375.2n 5)
XDUT MainReset MainClock EnableOut IB0 IB1 IB2 IB3 rOut0 rOut1 rOut2 rOut3 vdd 0 OutputRegister
CL0 rOut0 0 50f
CL1 rOut1 0 50f
CL2 rOut2 0 50f
CL3 rOut3 0 50f
.meas TRAN out_k0_b0 FIND V(rOut0) AT=38n
.meas TRAN out_k0_b1 FIND V(rOut1) AT=38n
.meas TRAN out_k0_b2 FIND V(rOut2) AT=38n
.meas TRAN out_k0_b3 FIND V(rOut3) AT=38n
.meas TRAN out_k1_b0 FIND V(rOut0) AT=78n
.meas TRAN out_k1_b1 FIND V(rOut1) AT=78n
.meas TRAN out_k1_b2 FIND V(rOut2) AT=78n
.meas TRAN out_k1_b3 FIND V(rOut3) AT=78n
.meas TRAN out_k2_b0 FIND V(rOut0) AT=118n
.meas TRAN out_k2_b1 FIND V(rOut1) AT=118n
.meas TRAN out_k2_b2 FIND V(rOut2) AT=118n
.meas TRAN out_k2_b3 FIND V(rOut3) AT=118n
.meas TRAN out_k3_b0 FIND V(rOut0) AT=158n
.meas TRAN out_k3_b1 FIND V(rOut1) AT=158n
.meas TRAN out_k3_b2 FIND V(rOut2) AT=158n
.meas TRAN out_k3_b3 FIND V(rOut3) AT=158n
.meas TRAN out_k4_b0 FIND V(rOut0) AT=198n
.meas TRAN out_k4_b1 FIND V(rOut1) AT=198n
.meas TRAN out_k4_b2 FIND V(rOut2) AT=198n
.meas TRAN out_k4_b3 FIND V(rOut3) AT=198n
.meas TRAN out_k5_b0 FIND V(rOut0) AT=238n
.meas TRAN out_k5_b1 FIND V(rOut1) AT=238n
.meas TRAN out_k5_b2 FIND V(rOut2) AT=238n
.meas TRAN out_k5_b3 FIND V(rOut3) AT=238n
.meas TRAN out_k6_b0 FIND V(rOut0) AT=278n
.meas TRAN out_k6_b1 FIND V(rOut1) AT=278n
.meas TRAN out_k6_b2 FIND V(rOut2) AT=278n
.meas TRAN out_k6_b3 FIND V(rOut3) AT=278n
.meas TRAN out_k7_b0 FIND V(rOut0) AT=318n
.meas TRAN out_k7_b1 FIND V(rOut1) AT=318n
.meas TRAN out_k7_b2 FIND V(rOut2) AT=318n
.meas TRAN out_k7_b3 FIND V(rOut3) AT=318n
.meas TRAN out_k8_b0 FIND V(rOut0) AT=358n
.meas TRAN out_k8_b1 FIND V(rOut1) AT=358n
.meas TRAN out_k8_b2 FIND V(rOut2) AT=358n
.meas TRAN out_k8_b3 FIND V(rOut3) AT=358n
.meas TRAN out_k9_b0 FIND V(rOut0) AT=398n
.meas TRAN out_k9_b1 FIND V(rOut1) AT=398n
.meas TRAN out_k9_b2 FIND V(rOut2) AT=398n
.meas TRAN out_k9_b3 FIND V(rOut3) AT=398n
.meas TRAN out_k10_b0 FIND V(rOut0) AT=438n
.meas TRAN out_k10_b1 FIND V(rOut1) AT=438n
.meas TRAN out_k10_b2 FIND V(rOut2) AT=438n
.meas TRAN out_k10_b3 FIND V(rOut3) AT=438n
.tran 0.01n 460n
.end
